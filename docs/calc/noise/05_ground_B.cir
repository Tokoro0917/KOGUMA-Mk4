* 05B Ground coupling, case B = MK4 PGND / GND split joined at NT1 (.tran)
* PGND: bulk caps C2-C4 (node 0) - trunk - C7/C8 + U1 GND (pA).
*       Motor driver GND -> NT1 point (pN) -> pA.  dnt = distance of NT1 from
*       the C7/C8 ground pad along the motor return path (0 = layout guidance:
*       NT1 at the GND pad of C7/C8).
*       Fan: R43 ground pad (pf) -> bulk caps.
*         2026-11-01: 20 mm of 0.5 mm trace, no Kelvin trace
*         2026-11-06: Q40/R43/J4 next to C2-C4 (3 mm, 1 mm wide) and a Kelvin
*                     PGND trace (20 mm x 0.15 mm) from the R43 pad to NT1
* GND : NT1 - MCU (gm) - sensor (gs), bottom-layer pour (3 mm eff. width).
* Filters (lib/blocks.lib SENSORBLK):
*   2026-11-01: rs2=1u rv=1u c51=0.8u   2026-11-06: R80 2.2, R51 2.2, C51 2.4u eff.
* Same currents and sensor as 05_ground_A.cir.
* Output: out/gndb_<old|new>_nt<d>mm.txt, out/gndb_<old|new>_off.txt
*         (time, vgerr = V(gs)-V(gm), vadc = V(out)-V(gm), vref = V(vdda)-V(gm))
.include lib/models.lib
.include lib/blocks.lib
.param dnt=0 imot=3 ifan=1.67 rs2=2.2 rv=2.2 c51=2.4u lpf=3 wpf=1 rkel=1u

Ifan 0 pf PULSE(0 {ifan} 0 50n 50n 11.95u 20u)
Imot 0 pm PULSE(0 {imot} 5u 30n 30n 9.97u 20u)

* PGND
Xtr  pA 0  TRACE len_mm=15 w_mm=0.5 lnh=0.7
Xpf  pf 0  TRACE len_mm={lpf} w_mm={wpf} lnh=0.5
Xkl  pf pk TRACE len_mm=20 w_mm=0.15 lnh=0.9
Rkel pk pN {rkel}
Xpm  pm pN TRACE len_mm=10 w_mm=0.5 lnh=0.7
Xnt  pN pA TRACE len_mm={dnt} w_mm=0.5 lnh=0.7
* GND (NT1 = node pN)
Xg1  gm pN TRACE len_mm=10 w_mm=3 lnh=0.4
Xg2  gs gm TRACE len_mm=20 w_mm=3 lnh=0.4

V33  v33 pA DC 3.3
Imcu v33 gm DC 150m
XS   v33 gs gm out vdda SENSORBLK iph=1u rs2={rs2} rv={rv} c51={c51}

.options method=gear
.control
set wr_singlescale
set wr_vecnames
* ================= 2026-11-06 schematic (new baseline) =================
alterparam ifan = 0
alterparam imot = 0
reset
destroy all
tran 5n 400u 200u 5n
let vgerr = v(gs)-v(gm)
let vadc = v(out)-v(gm)
let vref = v(vdda)-v(gm)
wrdata out/gndb_new_off.txt vgerr vadc vref
alterparam ifan = 1.67
alterparam imot = 3
foreach val 0 10 30
  alterparam dnt = $val
  reset
  destroy all
  tran 5n 400u 200u 5n
  let vgerr = v(gs)-v(gm)
  let vadc = v(out)-v(gm)
  let vref = v(vdda)-v(gm)
  set fn = "out/gndb_new_nt{$val}mm.txt"
  wrdata $fn vgerr vadc vref
end
* ================= 2026-11-01 schematic (before) =================
alterparam rs2 = 1u
alterparam rv = 1u
alterparam c51 = 0.8u
alterparam lpf = 20
alterparam wpf = 0.5
alterparam rkel = 1G
alterparam dnt = 0
alterparam ifan = 0
alterparam imot = 0
reset
destroy all
tran 5n 400u 200u 5n
let vgerr = v(gs)-v(gm)
let vadc = v(out)-v(gm)
let vref = v(vdda)-v(gm)
wrdata out/gndb_old_off.txt vgerr vadc vref
alterparam ifan = 1.67
alterparam imot = 3
foreach val 0 10 30
  alterparam dnt = $val
  reset
  destroy all
  tran 5n 400u 200u 5n
  let vgerr = v(gs)-v(gm)
  let vadc = v(out)-v(gm)
  let vref = v(vdda)-v(gm)
  set fn = "out/gndb_old_nt{$val}mm.txt"
  wrdata $fn vgerr vadc vref
end
quit
.endc
.end
